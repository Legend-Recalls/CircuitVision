* CircuitVision cir1 (topology + assigned values)
* 0=GND(electrical, raw GND nets collapsed)
R0 N13 N31 6  ; resistor
R1 N30 N32 4  ; resistor
R2 N12 N30 8  ; resistor
R3 N32 N31 8  ; resistor
R4 N14 N31 2  ; resistor
R5 N12 N13 4  ; resistor
R6 N13 N30 8  ; resistor
R7 N13 N14 10  ; resistor
R8 N13 N32 6  ; resistor
R9 N10 N12 6  ; resistor
ITEST N10 N30 DC 1
VREF N30 0 DC 0  ; B terminal as reference
* --- models ---
.model DMOD D
.model QMODN NPN
.model QMODP PNP
.model MMODN NMOS
.model MMODP PMOS
.model SMOD SW()
.op
.end
